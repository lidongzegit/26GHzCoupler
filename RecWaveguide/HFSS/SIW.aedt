# Ansys Electronics Desktop project, version 2018.1
materials:
  vacuum: permittivity=1
  copper: permeability=0.999991 conductivity=58000000
  silver: permeability=0.99998 conductivity=61000000
  FR4_epoxy: permittivity=4.4 dielectric_loss_tangent=0.02
  Taconic TLY (tm): permittivity=2.2 dielectric_loss_tangent=0.0009

design HFSSDesign1 (HFSS, DrivenModal, model units mm)
variables:
  a = 5mm
  l = 20mm
  b = 0.25mm
geometry:
  Box1 [Taconic TLY (tm)] = box(corner=(0mm, 0mm, 0mm), size=(l, a, b))
  Region [vacuum] = region(percentage_offset=0 on all sides)
boundaries and excitations:
  PerfE1: Perfect E Objects=Box1
  1: Wave Port Faces=Box1.face(-x) NumModes=1 Modes{Mode1{CharImp=Zpi}}
  2: Wave Port Faces=Box1.face(+x) NumModes=1 Modes{Mode1{CharImp=Zpi}}
mesh:
  Length1: LengthBased disabled Objects=Box1 MaxLength=2mm
  Length2: LengthBased Objects=Box1 MaxLength=1mm
  Length3: LengthBased disabled Objects=Box1 MaxLength=0.25mm
setups:
  Setup1: HfssDriven Frequency=26GHz MaxDeltaS=0.02 MaximumPasses=6 MinimumPasses=1 MinimumConvergedPasses=1 PercentRefinement=30 BasisOrder=1 PortAccuracy=2
    sweep Sweep: 10GHz to 50GHz step 0.1GHz; Type=Discrete
source amplitudes:
  1:1: 1W 0deg
  2:1: 0W 0deg
field plots:
  Mag_E1: E Field in Box1 on Setup1 : LastAdaptive at Freq=26GHz Phase=0deg
  Mesh1: MeshPlots in Box1 on Setup1 : LastAdaptive at Freq=26GHz Phase=0deg
reports:
  S Parameter Plot 1: dB(S(1,1)), dB(S(2,1)) vs Freq on Setup1 : Sweep; markers m1 at 20.3GHz

# Ansys Electronics Desktop project, version 2018.1
materials:
  vacuum: permittivity=1
  copper: permeability=0.999991 conductivity=58000000
  Neltec NY9220(IM) (tm): permittivity=2.2 dielectric_loss_tangent=0.0009
  Taconic TLY (tm): permittivity=2.2 dielectric_loss_tangent=0.0009

design HFSSDesign1 (HFSS, DrivenModal, model units mm)
variables:
  Dvia = 0.3mm
  Svp = 0.6mm
  Wapeture = 9.9mm
  Wtaper = 1.25mm
  Cvia = 0.4mm
  Ltaper = 2.75mm
  Cvp = 0.8mm
  h = 0.25mm
  Wsiw = 5.9mm
  W50 = 0.72mm
  L0 = 21mm
  W0 = 16mm
  hc = 0.035mm
  L50 = 5mm
  Wport = 2.5mm
  Hport = 1.5mm
geometry:
  ground = box(corner=(-Wapeture/2-4.8mm-Ltaper-L50, -W0/2, 0mm), size=(Wapeture+9.6mm+2*Ltaper+2*L50, W0, hc))
  substrate [Taconic TLY (tm)] = box(corner=(-Wapeture/2-4.8mm-Ltaper-L50, -W0/2, hc), size=(Wapeture+9.6mm+2*Ltaper+2*L50, W0, h))
  hole_C = cylinder(axis=Z, base_centre=(Wapeture/2, 0mm, 0mm), radius=Cvia/2, height=hc+h+hc)
  hole_D = cylinder(axis=Z, base_centre=(0, -Wsiw, 0mm), radius=Dvia/2, height=hc+h+hc)
  hole_C.duplicate_along_line(step=(0.8mm, 0mm, 0mm), total=7, attached)
  hole_C_wai = cylinder(axis=Z, base_centre=(Wapeture/2, 0mm, 0mm), radius=Cvia/2, height=hc+h)
  hole_C_wai.move(5.6mm, 0mm, 0mm)
  taper1 = rectangle(corner=(Wapeture/2+4.8mm, -Wsiw/2-Wtaper/2, h+hc), y_size=Wtaper, z_size=hc)
  Rectangle2 = rectangle(corner=(Wapeture/2+4.8mm+Ltaper, -Wsiw/2-W50/2, h+hc), y_size=W50, z_size=hc)
  taper1.connect(Rectangle2)
  50ohm_1 = box(corner=(Wapeture/2+4.8mm+Ltaper, -Wsiw/2-W50/2, h+hc), size=(L50, W50, hc))
  hole_C_wai.duplicate_along_line(step=(0.8mm, 0mm, 0mm), total=9, attached)
  hole_C.unite(hole_C_wai)
  hole_C_mi = hole_C.duplicate_mirror(point=(0mm, 0mm, 0mm), normal=(-1mm, 0mm, 0mm))
  hole_C.unite(hole_C_mi)
  50ohm_1.unite(taper1)
  50ohm_2 = 50ohm_1.duplicate_mirror(point=(0mm, 0mm, 0mm), normal=(-1mm, 0mm, 0mm))
  50ohm_3 = 50ohm_2.duplicate_mirror(point=(0mm, 0mm, 0mm), normal=(0mm, 1mm, 0mm))
  50ohm_4 = 50ohm_1.duplicate_mirror(point=(0mm, 0mm, 0mm), normal=(0mm, 1mm, 0mm))
  airbox [vacuum] = box(corner=(-Wapeture/2-4.8mm-Ltaper-L50, -W0/2-5mm, 0), size=(Wapeture+9.6mm+2*Ltaper+2*L50, W0+10mm, h+hc+hc+10mm))
  waveguide [copper] = box(corner=(-Wapeture/2-4.8mm, -W0/2, h+hc), size=(Wapeture+9.6mm, W0, hc))
  port1 = rectangle(corner=(Wapeture/2+4.8mm+Ltaper+L50, -Wsiw/2-Wport/2, 0), y_size=Wport, z_size=Hport)
  port2 = port1.duplicate_mirror(point=(0mm, 0mm, 0mm), normal=(-1mm, 0mm, 0mm))
  port3 = port2.duplicate_mirror(point=(0mm, 0mm, 0mm), normal=(0mm, 1mm, 0mm))
  port4 = port1.duplicate_mirror(point=(0mm, 0mm, 0mm), normal=(0mm, 1mm, 0mm))
  50ohm_1.unite(50ohm_2, 50ohm_3, 50ohm_4)
  waveguide.unite(50ohm_1)
  waveguide.unite(ground, hole_C)
  Box1 = box(corner=(Wapeture/2+4.8mm-0.15mm, -Wsiw-0.15mm, 0mm), size=(0.15mm, 0.3mm, h+hc+hc))
  hole_D.duplicate_along_line(step=(0.6mm, 0mm, 0mm), total=17, attached)
  hole_D1 = cylinder(axis=Z, base_centre=(0, -Wsiw, 0mm), radius=Dvia/2, height=hc+h)
  hole_D1.move(10.2mm, 0mm, 0mm)
  hole_D1.duplicate_along_line(step=(0.6mm, 0mm, 0mm), total=5, attached)
  hole_D.unite(Box1, hole_D1)
  hole_D_1 = hole_D.duplicate_mirror(point=(0mm, 0mm, 0mm), normal=(0mm, -1mm, 0mm))
  hole_D_2 = hole_D.duplicate_mirror(point=(0mm, 0mm, 0mm), normal=(-1mm, 0mm, 0mm))
  hole_D_1_1 = hole_D_1.duplicate_mirror(point=(0mm, 0mm, 0mm), normal=(-1mm, 0mm, 0mm))
  hole_D.unite(hole_D_1, hole_D_1_1, hole_D_2)
  waveguide.unite(hole_D)
  waveguide_1 = waveguide.copy()
  substrate.subtract(waveguide_1)
boundaries and excitations:
  Rad1: Radiation Objects=airbox
  1: Wave Port Objects=port1 NumModes=1 Modes{Mode1{CharImp=Zpi RenormImp=50ohm}}
  2: Wave Port Objects=port2 NumModes=1 Modes{Mode1{CharImp=Zpi RenormImp=50ohm}}
  3: Wave Port Objects=port3 NumModes=1 Modes{Mode1{CharImp=Zpi RenormImp=50ohm}}
  4: Wave Port Objects=port4 NumModes=1 Modes{Mode1{CharImp=Zpi RenormImp=50ohm}}
mesh:
  Length1: LengthBased disabled Objects=substrate MaxLength=8mm
  Length2: LengthBased disabled Objects=substrate MaxLength=4mm
  Length3: LengthBased Objects=substrate MaxLength=1mm
setups:
  Setup1: HfssDriven Frequency=26GHz MaxDeltaS=0.02 MaximumPasses=6 MinimumPasses=1 MinimumConvergedPasses=1 PercentRefinement=30 BasisOrder=1 PortAccuracy=2
source amplitudes:
  1:1: 1W 0deg
  2:1, 3:1, 4:1: 0W 0deg
field plots:
  Mag_E1: E Field in substrate on Setup1 : LastAdaptive at Freq=26GHz Phase=0deg
  Mesh1: MeshPlots in substrate on Setup1 : LastAdaptive at Freq=26GHz Phase=0deg
